* Faithful ngspice deck auto-generated from lc_filter_square_wave.asc
* generated by asc2ngspice.py from /home/soumajinno/text_power_electronics/book/figures/ltspice/chapter04/lc_filter_square_wave.asc
* NOTE: LTspice Rser/Lser expanded to explicit series R/L; pi injected;
*       .tran startup -> uic ; params topologically sorted;
*       eta/micro spelled in ASCII (see to_ascii_card).

.param pi=3.14159265358979

* ---- parameters ----

* ---- models / options / coupling ----
* ngspice numeric convergence aids (NOT a circuit change): itl4=1000
*   (per the .asc convergence memo ngspice recipe) and trtol=100 relax
*   LTE/step-control so the stiff behavioural-switch + body-diode
*   commutations do not collapse the timestep.  They are DEFAULTS: in
*   ngspice the LAST .options wins, so a key is emitted here only when
*   the .asc's own .options cards above do not already set it.
.options itl4=1000 trtol=100

* ---- devices ----
L1 N001 N002 100u
V1 N001 0 PULSE(0 12 0 1n 1n 5u 10u)
C1 N002 0 10u
R1 N002 0 6

* original LTspice: .tran 0.01u 300u 250u 0.01u   (startup->uic)
.tran 0.01u 300u 250u 0.01u

.end
