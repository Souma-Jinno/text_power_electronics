* Faithful ngspice deck auto-generated from hbridge_pwm_unipolar.asc
* generated by asc2ngspice.py from /home/soumajinno/text_power_electronics/book/figures/ltspice/chapter09/hbridge_pwm_unipolar.asc
* NOTE: LTspice Rser/Lser expanded to explicit series R/L; pi injected;
*       .tran startup -> uic ; params topologically sorted;
*       eta/micro spelled in ASCII (see to_ascii_card).

.param pi=3.14159265358979

* ---- parameters ----
.param E=100
.param fc=5k
.param fm=50
.param m=0.8
.param R=10
.param L=10m

* ---- models / options / coupling ----
.model SW SW(Ron=10m Roff=1G Vt=0.5)
.options reltol=0.01 gmin=1e-9
.control
tran 0.5u 60m 20m 2u
let vab = v(a) - v(b)
let sinref = sin(2*3.14159265358979*50*time)
let ib = vab*sinref
meas tran vmax max vab from=20m to=59.9m
meas tran vmin min vab from=20m to=59.9m
meas tran vzero_check avg vab from=20m to=59.9m
meas tran irms rms i(l1) from=20m to=59.9m
meas tran ipeak max i(l1) from=20m to=59.9m
meas tran ib_1 integ ib from=20m to=39.9m
write chapter09/hbridge_pwm_unipolar.raw all
linearize vab
fft vab
.endc
* ngspice numeric convergence aids (NOT a circuit change): itl4=1000
*   (per the .asc convergence memo ngspice recipe) and trtol=100 relax
*   LTE/step-control so the stiff behavioural-switch + body-diode
*   commutations do not collapse the timestep.  They are DEFAULTS: in
*   ngspice the LAST .options wins, so a key is emitted here only when
*   the .asc's own .options cards above do not already set it.
.options itl4=1000 trtol=100

* ---- devices ----
V1 n1 0 100
S1 n2 n3 n4 n5 SW
S2 n6 0 n7 n8 SW
S3 n9 b n10 n11 SW
S4 n12 0 n13 n14 SW
R1 n15 n16 10
L1 n17 n18 10m
VBcarr n19 0 V=(2/pi*asin(sin(2*pi*fc*time)))
VBref n20 0 V=(m*sin(2*pi*fm*time))
VBrefn n21 0 V=(-m*sin(2*pi*fm*time))
VBctrlA n22 0 V=((V(ref)>V(carr))?1:0)
VBctrlAn n23 0 V=((V(ref)<V(carr))?1:0)
VBctrlB n24 0 V=((V(refn)>V(carr))?1:0)
VBctrlBn n25 0 V=((V(refn)<V(carr))?1:0)

.end
