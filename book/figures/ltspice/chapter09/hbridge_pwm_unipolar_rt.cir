* Faithful ngspice deck auto-generated from hbridge_pwm_unipolar.asc
* generated by asc2ngspice.py from /home/soumajinno/text_power_electronics/book/figures/ltspice/chapter09/hbridge_pwm_unipolar.asc
* NOTE: LTspice Rser/Lser expanded to explicit series R/L; pi injected;
*       .tran startup -> uic ; params topologically sorted;
*       eta/micro spelled in ASCII (see to_ascii_card).

.param pi=3.14159265358979

* ---- parameters ----
.param E=100
.param fc=5k
.param fm=50
.param m=0.8
.param R=10
.param L=10m

* ---- models / options / coupling ----
.model SW SW(Ron=10m Roff=1G Vt=0.5)
.options reltol=0.01 gmin=1e-9
Bcarr carr 0 V=(2/pi*asin(sin(2*pi*fc*time)))
Bref ref 0 V=(m*sin(2*pi*fm*time))
Brefn refn 0 V=(-m*sin(2*pi*fm*time))
BctrlA ctrlA 0 V=((V(ref)>V(carr))?1:0)
BctrlAn ctrlAn 0 V=((V(ref)<V(carr))?1:0)
BctrlB ctrlB 0 V=((V(refn)>V(carr))?1:0)
BctrlBn ctrlBn 0 V=((V(refn)<V(carr))?1:0)
* ngspice numeric convergence aids (NOT a circuit change): itl4=1000
*   (per the .asc convergence memo ngspice recipe) and trtol=100 relax
*   LTE/step-control so the stiff behavioural-switch + body-diode
*   commutations do not collapse the timestep.  They are DEFAULTS: in
*   ngspice the LAST .options wins, so a key is emitted here only when
*   the .asc's own .options cards above do not already set it.
.options itl4=1000 trtol=100

* ---- devices ----
S3 N001 b ctrlB 0 SW
L1 N002 b 10m
R1 a N002 10
S2 a 0 ctrlAn 0 SW
S1 N001 a ctrlA 0 SW
V1 N001 0 100
S4 b 0 ctrlBn 0 SW

.end
