* Faithful ngspice deck auto-generated from phase_control_rl_load.asc
* generated by asc2ngspice.py from /home/soumajinno/text_power_electronics/book/figures/ltspice/chapter10/phase_control_rl_load.asc
* NOTE: LTspice Rser/Lser expanded to explicit series R/L; pi injected;
*       .tran startup -> uic ; params topologically sorted;
*       eta/micro spelled in ASCII (see to_ascii_card).

.param pi=3.14159265358979

* ---- parameters ----

* ---- models / options / coupling ----
.model QNPN2 NPN(BF=50)
.model QPNP2 PNP(BF=50)
* ngspice numeric convergence aids (NOT a circuit change): itl4=1000
*   (per the .asc convergence memo ngspice recipe) and trtol=100 relax
*   LTE/step-control so the stiff behavioural-switch + body-diode
*   commutations do not collapse the timestep.  They are DEFAULTS: in
*   ngspice the LAST .options wins, so a key is emitted here only when
*   the .asc's own .options cards above do not already set it.
.options itl4=1000 trtol=100

* ---- devices ----
Vin vin_p 0 SIN(0 141 50)
Rsrc vin_p vline 0.5
Rload vline rl_mid 100
Lload rl_mid mid 300m
Q2p gbasep bbasep mid QPNP2
Q1p bbasep gbasep 0 QNPN2
Rshuntp gbasep 0 1k
Igatep 0 gbasep PULSE(0 10m 3.3333m 1u 1u 1m 20m)
Q2n gbasen bbasen 0 QPNP2
Q1n bbasen gbasen mid QNPN2
Rshuntn gbasen mid 1k
Igaten mid gbasen PULSE(0 10m 13.3333m 1u 1u 1m 20m)

.end
