* Faithful ngspice deck auto-generated from phase_control_r_load.asc
* generated by asc2ngspice.py from /home/soumajinno/text_power_electronics/book/figures/ltspice/chapter10/phase_control_r_load.asc
* NOTE: LTspice Rser/Lser expanded to explicit series R/L; pi injected;
*       .tran startup -> uic ; params topologically sorted;
*       eta/micro spelled in ASCII (see to_ascii_card).

.param pi=3.14159265358979

* ---- parameters ----
.param adelp=1.6667m
.param adeln=11.6667m

* ---- models / options / coupling ----
.model QNPN2 NPN(BF=50)
.model QPNP2 PNP(BF=50)
.control
tran 10u 100m
meas tran irms_a30 RMS i(Vin) FROM=60m TO=99.9m
alterparam adelp = 3.3333m
alterparam adeln = 13.3333m
reset
tran 10u 100m
meas tran irms_a60 RMS i(Vin) FROM=60m TO=99.9m
alterparam adelp = 5.0m
alterparam adeln = 15.0m
reset
tran 10u 100m
meas tran irms_a90 RMS i(Vin) FROM=60m TO=99.9m
alterparam adelp = 6.6667m
alterparam adeln = 16.6667m
reset
tran 10u 100m
meas tran irms_a120 RMS i(Vin) FROM=60m TO=99.9m
alterparam adelp = 8.3333m
alterparam adeln = 18.3333m
reset
tran 10u 100m
meas tran irms_a150 RMS i(Vin) FROM=60m TO=99.9m
write chapter10/phase_control_r_load.raw all
.endc
* ngspice numeric convergence aids (NOT a circuit change): itl4=1000
*   (per the .asc convergence memo ngspice recipe) and trtol=100 relax
*   LTE/step-control so the stiff behavioural-switch + body-diode
*   commutations do not collapse the timestep.  They are DEFAULTS: in
*   ngspice the LAST .options wins, so a key is emitted here only when
*   the .asc's own .options cards above do not already set it.
.options itl4=1000 trtol=100

* ---- devices ----
Vin n1 0 SIN(0 141 50)
Rsrc n2 n3 0.5
Rload n4 n5 100
* UNHANDLED SYMBOL Q2p (pnp): nodes=[]
* UNHANDLED SYMBOL Q1p (npn): nodes=[]
Rshuntp n6 n7 1k
* UNHANDLED SYMBOL Igatep (current): nodes=[]
* UNHANDLED SYMBOL Q2n (pnp): nodes=[]
* UNHANDLED SYMBOL Q1n (npn): nodes=[]
Rshuntn n8 n9 1k
* UNHANDLED SYMBOL Igaten (current): nodes=[]

.end
