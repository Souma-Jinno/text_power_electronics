* Faithful ngspice deck auto-generated from switching_loss_double_pulse.asc
* generated by asc2ngspice.py from /home/soumajinno/text_power_electronics/book/figures/ltspice/chapter03/switching_loss_double_pulse.asc
* NOTE: LTspice Rser/Lser expanded to explicit series R/L; pi injected;
*       .tran startup -> uic ; params topologically sorted;
*       eta/micro spelled in ASCII (see to_ascii_card).

.param pi=3.14159265358979

* ---- parameters ----

* ---- models / options / coupling ----
.model SWMOS NMOS(LEVEL=1 VTO=3 KP=2)
.model DFW D(Is=1e-9 N=1.0 Rs=0.001)
M1 sw gate 0 0 SWMOS
* ngspice numeric convergence aids (NOT a circuit change): itl4=1000
*   (per the .asc convergence memo ngspice recipe) and trtol=100 relax
*   LTE/step-control so the stiff behavioural-switch + body-diode
*   commutations do not collapse the timestep.  They are DEFAULTS: in
*   ngspice the LAST .options wins, so a key is emitted here only when
*   the .asc's own .options cards above do not already set it.
.options itl4=1000 trtol=100

* ---- devices ----
L1 vtop sw 50u
V1 vtop 0 100
D1 sw vtop DFW
Coss sw 0 470p
VG gate 0 PWL(0 0 100n 0 150n 15 5150n 15 5200n 0 6200n 0 6250n 15 8250n 15 8300n 0 8500n 0)

.end
