* Faithful ngspice deck auto-generated from buckboost_chopper.asc
* generated by asc2ngspice.py from /home/soumajinno/text_power_electronics/book/figures/ltspice/chapter05/buckboost_chopper.asc
* NOTE: LTspice Rser/Lser expanded to explicit series R/L; pi injected;
*       .tran startup -> uic ; params topologically sorted;
*       eta/micro spelled in ASCII (see to_ascii_card).

.param pi=3.14159265358979

* ---- parameters ----
.param fsw=20k
.param Tsw=1/fsw
.param D=0.2941

* ---- models / options / coupling ----
.model SW SW(Ron=1m Roff=1G Vt=0.01)
.model DMOD D(Is=1e-9 N=1.0 Rs=0.001)
* ngspice numeric convergence aids (NOT a circuit change): itl4=1000
*   (per the .asc convergence memo ngspice recipe) and trtol=100 relax
*   LTE/step-control so the stiff behavioural-switch + body-diode
*   commutations do not collapse the timestep.  They are DEFAULTS: in
*   ngspice the LAST .options wins, so a key is emitted here only when
*   the .asc's own .options cards above do not already set it.
.options itl4=1000 trtol=100

* ---- devices ----
V1 N001 0 12
S1 N001 N002 ctrl 0 SW
D1 N003 N002 DMOD
L1 N002 0 700u
C1 N003 0 500u
R1 N003 0 5
V2 ctrl 0 PULSE(0 10 0 10n 10n {Tsw*D} {Tsw})

* original LTspice: .tran 2u 100m 95m   (startup->uic)
.tran 2u 100m 95m

.end
