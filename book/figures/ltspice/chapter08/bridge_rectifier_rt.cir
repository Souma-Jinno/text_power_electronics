* Faithful ngspice deck auto-generated from bridge_rectifier.asc
* generated by asc2ngspice.py from /home/soumajinno/text_power_electronics/book/figures/ltspice/chapter08/bridge_rectifier.asc
* NOTE: LTspice Rser/Lser expanded to explicit series R/L; pi injected;
*       .tran startup -> uic ; params topologically sorted;
*       eta/micro spelled in ASCII (see to_ascii_card).

.param pi=3.14159265358979

* ---- parameters ----

* ---- models / options / coupling ----
.model DMOD D(Is=1e-9 N=1.0 Rs=0.001)
.options reltol=0.01 gmin=1e-9
* ngspice numeric convergence aids (NOT a circuit change): itl4=1000
*   (per the .asc convergence memo ngspice recipe) and trtol=100 relax
*   LTE/step-control so the stiff behavioural-switch + body-diode
*   commutations do not collapse the timestep.  They are DEFAULTS: in
*   ngspice the LAST .options wins, so a key is emitted here only when
*   the .asc's own .options cards above do not already set it.
.options itl4=1000 trtol=100

* ---- devices ----
D2 N002 vout DMOD
V1 N003 N002 SIN(0 141 50)
Rsrc N003 N001 5
D3 0 N001 DMOD
D1 N001 vout DMOD
C1 vout 0 1000u
R1 vout 0 100
D4 0 N002 DMOD

.end
