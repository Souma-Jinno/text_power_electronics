* Faithful ngspice deck auto-generated from pn_junction_iv.asc
* generated by asc2ngspice.py from /home/soumajinno/text_power_electronics/book/figures/ltspice/chapter01/pn_junction_iv.asc
* NOTE: LTspice Rser/Lser expanded to explicit series R/L; pi injected;
*       .tran startup -> uic ; params topologically sorted;
*       eta/micro spelled in ASCII (see to_ascii_card).

.param pi=3.14159265358979

* ---- parameters ----

* ---- models / options / coupling ----
.model DMOD D(Is=1e-14 N=1.0 Rs=0.1)
.dc V1 -5 1 0.01
* ngspice numeric convergence aids (NOT a circuit change): itl4=1000
*   (per the .asc convergence memo ngspice recipe) and trtol=100 relax
*   LTE/step-control so the stiff behavioural-switch + body-diode
*   commutations do not collapse the timestep.  They are DEFAULTS: in
*   ngspice the LAST .options wins, so a key is emitted here only when
*   the .asc's own .options cards above do not already set it.
.options itl4=1000 trtol=100

* ---- devices ----
V1 N001 0 0
R1 N001 N002 1k
D1 N002 0 DMOD

.end
