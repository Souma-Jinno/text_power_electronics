* duplicate element name test
V1 in 0 5
R1 in mid 1k
R1 mid 0 2k
R2 in 0 1k
.op
.end
