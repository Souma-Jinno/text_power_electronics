* Faithful ngspice deck auto-generated from linear_reg_opamp.asc
* generated by asc2ngspice.py from /home/soumajinno/text_power_electronics/book/figures/ltspice/chapter07/linear_reg_opamp.asc
* NOTE: LTspice Rser/Lser expanded to explicit series R/L; pi injected;
*       .tran startup -> uic ; params topologically sorted;
*       eta/micro spelled in ASCII (see to_ascii_card).

.param pi=3.14159265358979

* ---- parameters ----

* ---- models / options / coupling ----
.model QNPN3 NPN(BF=100)
.control
alter R2 = 10
tran 2u 5m
alter R2 = 50
tran 2u 5m
alter R2 = 100
tran 2u 5m
write chapter07/linear_reg_opamp.raw all
.endc
* ngspice numeric convergence aids (NOT a circuit change): itl4=1000
*   (per the .asc convergence memo ngspice recipe) and trtol=100 relax
*   LTE/step-control so the stiff behavioural-switch + body-diode
*   commutations do not collapse the timestep.  They are DEFAULTS: in
*   ngspice the LAST .options wins, so a key is emitted here only when
*   the .asc's own .options cards above do not already set it.
.options itl4=1000 trtol=100

* ---- devices ----
V4 n1 0 10
* UNHANDLED SYMBOL Q1 (npn): nodes=[]
R3 n2 n3 6k
R4 n4 n5 12k
R2 n6 n7 10
V3 n8 0 PULSE(0 5 0.2m 10n 10n 10m)
* UNHANDLED SYMBOL E1 (opamp): nodes=[]

.end
