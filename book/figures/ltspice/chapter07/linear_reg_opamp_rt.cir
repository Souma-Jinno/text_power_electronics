* Faithful ngspice deck auto-generated from linear_reg_opamp.asc
* generated by asc2ngspice.py from /home/soumajinno/text_power_electronics/book/figures/ltspice/chapter07/linear_reg_opamp.asc
* NOTE: LTspice Rser/Lser expanded to explicit series R/L; pi injected;
*       .tran startup -> uic ; params topologically sorted;
*       eta/micro spelled in ASCII (see to_ascii_card).

.param pi=3.14159265358979

* ---- parameters ----

* ---- models / options / coupling ----
.model QNPN3 NPN(BF=100)
E1 N002 0 vref vfb 1e5
* ngspice numeric convergence aids (NOT a circuit change): itl4=1000
*   (per the .asc convergence memo ngspice recipe) and trtol=100 relax
*   LTE/step-control so the stiff behavioural-switch + body-diode
*   commutations do not collapse the timestep.  They are DEFAULTS: in
*   ngspice the LAST .options wins, so a key is emitted here only when
*   the .asc's own .options cards above do not already set it.
.options itl4=1000 trtol=100

* ---- devices ----
V4 N001 0 10
Q1 N001 N002 vout QNPN3
R3 vout vfb 6k
R4 vfb 0 12k
R2 vout 0 10
V3 vref 0 PULSE(0 5 0.2m 10n 10n 10m)

.end
