* Faithful ngspice deck auto-generated from linear_reg_zener.asc
* generated by asc2ngspice.py from /home/soumajinno/text_power_electronics/book/figures/ltspice/chapter07/linear_reg_zener.asc
* NOTE: LTspice Rser/Lser expanded to explicit series R/L; pi injected;
*       .tran startup -> uic ; params topologically sorted;
*       eta/micro spelled in ASCII (see to_ascii_card).

.param pi=3.14159265358979

* ---- parameters ----

* ---- models / options / coupling ----
.model QNPN3 NPN(BF=100)
.model DZ4V7 D(Is=1e-9 N=1.0 Rs=1 BV=4.7 IBV=0.005)
.control
alter R1 = 10
tran 10u 1m
alter R1 = 50
tran 10u 1m
alter R1 = 100
tran 10u 1m
write chapter07/linear_reg_zener.raw all
.endc
* ngspice numeric convergence aids (NOT a circuit change): itl4=1000
*   (per the .asc convergence memo ngspice recipe) and trtol=100 relax
*   LTE/step-control so the stiff behavioural-switch + body-diode
*   commutations do not collapse the timestep.  They are DEFAULTS: in
*   ngspice the LAST .options wins, so a key is emitted here only when
*   the .asc's own .options cards above do not already set it.
.options itl4=1000 trtol=100

* ---- devices ----
V1 n1 0 10
R2 n2 vref 400
* UNHANDLED SYMBOL D1 (zener): nodes=[]
* UNHANDLED SYMBOL Q1 (npn): nodes=[]
R1 n3 n4 10

.end
