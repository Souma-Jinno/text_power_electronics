* Faithful ngspice deck auto-generated from igbt_equivalent_von.asc
* generated by asc2ngspice.py from /home/soumajinno/text_power_electronics/book/figures/ltspice/chapter02/igbt_equivalent_von.asc
* NOTE: LTspice Rser/Lser expanded to explicit series R/L; pi injected;
*       .tran startup -> uic ; params topologically sorted;
*       eta/micro spelled in ASCII (see to_ascii_card).

.param pi=3.14159265358979

* ---- parameters ----

* ---- models / options / coupling ----
.model MYNMOS NMOS(LEVEL=1 VTO=3 KP=2)
.model DMOD D(Is=1e-9 N=1.0 Rs=0.001)
.control
dc Isweep 0.1 60 0.1
print v(vcol) v(vmid)
write chapter02/igbt_equivalent_von.raw
.endc
* ngspice numeric convergence aids (NOT a circuit change): itl4=1000
*   (per the .asc convergence memo ngspice recipe) and trtol=100 relax
*   LTE/step-control so the stiff behavioural-switch + body-diode
*   commutations do not collapse the timestep.  They are DEFAULTS: in
*   ngspice the LAST .options wins, so a key is emitted here only when
*   the .asc's own .options cards above do not already set it.
.options itl4=1000 trtol=100

* ---- devices ----
M1 n1 n2 n3 n3 MYNMOS
D1 n3 n4 DMOD
VGG n5 0 15
* UNHANDLED SYMBOL Isweep (current): nodes=[]

.end
