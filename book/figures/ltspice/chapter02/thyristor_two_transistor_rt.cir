* Faithful ngspice deck auto-generated from thyristor_two_transistor.asc
* generated by asc2ngspice.py from /home/soumajinno/text_power_electronics/book/figures/ltspice/chapter02/thyristor_two_transistor.asc
* NOTE: LTspice Rser/Lser expanded to explicit series R/L; pi injected;
*       .tran startup -> uic ; params topologically sorted;
*       eta/micro spelled in ASCII (see to_ascii_card).

.param pi=3.14159265358979

* ---- parameters ----

* ---- models / options / coupling ----
.model QNPN2 NPN(BF=50)
.model QPNP2 PNP(BF=50)
.control
tran 10u 10m
print v(anode) v(gbase) i(vaa)
write chapter02/thyristor_two_transistor.raw
.endc
* ngspice numeric convergence aids (NOT a circuit change): itl4=1000
*   (per the .asc convergence memo ngspice recipe) and trtol=100 relax
*   LTE/step-control so the stiff behavioural-switch + body-diode
*   commutations do not collapse the timestep.  They are DEFAULTS: in
*   ngspice the LAST .options wins, so a key is emitted here only when
*   the .asc's own .options cards above do not already set it.
.options itl4=1000 trtol=100

* ---- devices ----
VAA n1 0 12
RL n2 anode 100
* UNHANDLED SYMBOL Q2 (pnp): nodes=[]
* UNHANDLED SYMBOL Q1 (npn): nodes=[]
* UNHANDLED SYMBOL Igate (current): nodes=[]
Rshunt n3 n4 1k

.end
