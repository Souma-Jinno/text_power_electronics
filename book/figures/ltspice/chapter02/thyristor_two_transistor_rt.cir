* Faithful ngspice deck auto-generated from thyristor_two_transistor.asc
* generated by asc2ngspice.py from /home/soumajinno/text_power_electronics/book/figures/ltspice/chapter02/thyristor_two_transistor.asc
* NOTE: LTspice Rser/Lser expanded to explicit series R/L; pi injected;
*       .tran startup -> uic ; params topologically sorted;
*       eta/micro spelled in ASCII (see to_ascii_card).

.param pi=3.14159265358979

* ---- parameters ----

* ---- models / options / coupling ----
.model QNPN2 NPN(BF=50)
.model QPNP2 PNP(BF=50)
* ngspice numeric convergence aids (NOT a circuit change): itl4=1000
*   (per the .asc convergence memo ngspice recipe) and trtol=100 relax
*   LTE/step-control so the stiff behavioural-switch + body-diode
*   commutations do not collapse the timestep.  They are DEFAULTS: in
*   ngspice the LAST .options wins, so a key is emitted here only when
*   the .asc's own .options cards above do not already set it.
.options itl4=1000 trtol=100

* ---- devices ----
VAA N001 0 12
RL N001 anode 100
Q2 gbase N002 anode QPNP2
Q1 N002 gbase 0 QNPN2
Igate 0 gbase PULSE(0 10m 1m 1u 1u 1m 100m)
Rshunt gbase 0 1k

.end
