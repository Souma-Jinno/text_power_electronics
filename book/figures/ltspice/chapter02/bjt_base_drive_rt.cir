* Faithful ngspice deck auto-generated from bjt_base_drive.asc
* generated by asc2ngspice.py from /home/soumajinno/text_power_electronics/book/figures/ltspice/chapter02/bjt_base_drive.asc
* NOTE: LTspice Rser/Lser expanded to explicit series R/L; pi injected;
*       .tran startup -> uic ; params topologically sorted;
*       eta/micro spelled in ASCII (see to_ascii_card).

.param pi=3.14159265358979

* ---- parameters ----

* ---- models / options / coupling ----
.model QNPN NPN(BF=50)
.control
op
print v(ncoll) v(nbase) @q1[ic] @q1[ib] @q1[ie] @q1[vbe]
write chapter02/bjt_base_drive.raw
.endc
* ngspice numeric convergence aids (NOT a circuit change): itl4=1000
*   (per the .asc convergence memo ngspice recipe) and trtol=100 relax
*   LTE/step-control so the stiff behavioural-switch + body-diode
*   commutations do not collapse the timestep.  They are DEFAULTS: in
*   ngspice the LAST .options wins, so a key is emitted here only when
*   the .asc's own .options cards above do not already set it.
.options itl4=1000 trtol=100

* ---- devices ----
V1 n1 0 12
RC n2 ncoll 0.02
* UNHANDLED SYMBOL I1 (current): nodes=[]
* UNHANDLED SYMBOL Q1 (npn): nodes=[]

.end
